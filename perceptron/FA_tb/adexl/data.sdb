ADE simulation setup
Run mode: Single Run, Sweeps and Corners
Tests:
  perceptron:FA_tb:1: perceptron/FA_tb/schematic, simulator spectre
Global variables:
  L = 120n
  VDD = 1
  Wn = 120n
  Tclk = 120n
