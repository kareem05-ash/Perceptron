ADE simulation setup
Run mode: Single Run, Sweeps and Corners
Tests:
  perceptron:Barrel_Shifter_tb:1: perceptron/Barrel_Shifter_tb/schematic, simulator spectre
Global variables:
  A0 = 1
  A1 = 0
  A2 = 1
  A3 = 0
  L = 120n
  S0 = 0
  S1 = 1
  VDD = 1
  Wn = 120n
