ADE simulation setup
Run mode: Single Run, Sweeps and Corners
Tests:
  perceptron:2:1_MUX_tb:1: perceptron/2:1_MUX_tb/schematic, simulator spectre
Global variables:
  L = 120n
  Tclk = 100n
  VDD = 1
  Wn = 120n
