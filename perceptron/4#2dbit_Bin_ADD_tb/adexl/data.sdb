ADE simulation setup
Run mode: Single Run, Sweeps and Corners
Tests:
  perceptron:4-bit_Bin_ADD_tb:1: perceptron/4-bit_Bin_ADD_tb/schematic, simulator spectre
Global variables:
  A0 = 0
  A1 = 1
  A2 = 1
  A3 = 0
  B0 = 1
  B1 = 0
  B2 = 1
  B3 = 0
  CIn = 0
  L = 120n
  VDD = 1
  Wn = 120n
  Tclk = 100n
  Tclka = 80n
