ADE simulation setup
Run mode: Single Run, Sweeps and Corners
Tests:
  perceptron:MUX_tb2:1: perceptron/MUX_tb2/schematic, simulator spectre
Global variables:
  L = 120n
  Tclk = 120n
  VDD = 1
  Wn = 120n
  clk = 120n
