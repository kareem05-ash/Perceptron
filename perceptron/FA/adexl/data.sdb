ADE simulation setup
Run mode: Single Run, Sweeps and Corners
Tests:
  perceptron:FA:1: perceptron/FA/schematic, simulator spectre
Global variables:
  A = 1
  B = 0
  Cin = 1
  L = 120n
  VDD = 1
  Wn = 120n
