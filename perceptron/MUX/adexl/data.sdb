ADE simulation setup
Run mode: Single Run, Sweeps and Corners
Tests:
  perceptron:MUX:1: perceptron/MUX/schematic, simulator spectre
Global variables:
  L = 120n
  Tclk = 100n
  VDD = 1
  Wn = 120n
