ADE simulation setup
Run mode: Single Run, Sweeps and Corners
Tests:
  perceptron:top_tb:1: perceptron/top_tb/schematic, simulator spectre
Global variables:
  L = 120n
  VDD = 1
  Wn = 120n
  W00 = 0
  W01 = 1
  W10 = 1
  W11 = 1
  X00 = 0
  X01 = 1
  X02 = 1
  X03 = 1
  X10 = 1
  X11 = 0
  X12 = 0
  X13 = 0
