ADE simulation setup
Run mode: Single Run, Sweeps and Corners
Tests:
  perceptron:INV_tst:1: perceptron/INV_tst/schematic, simulator spectre
Global variables:
  L = 60n
  Tclk = 100n
  VDD = 1
  Wn = 120n
